** sch_path: /foss/designs/tugas/xsch/untitled.sch
**.subckt untitled
XM1 out in 0 0 sky130_fd_pr__nfet_01v8 L=0.15 W=3 nf=1 ad=0.87 as=0.87 pd=6.58 ps=6.58 nrd=0.0966666666666667
+ nrs=0.0966666666666667 sa=0 sb=0 sd=0 mult=1
XM2 out in net1 net1 sky130_fd_pr__pfet_01v8 L=0.15 W=9 nf=1 ad=2.61 as=2.61 pd=18.58 ps=18.58 nrd=0.0322222222222222
+ nrs=0.0322222222222222 sa=0 sb=0 sd=0 mult=1
V1 in 0 0
V2 net1 0 1.8
**** begin user architecture code

blabla

**** end user architecture code
**.ends
.end
